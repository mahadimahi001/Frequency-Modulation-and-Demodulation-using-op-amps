FM TRANSMITTER + DIFFERENTIATOR SLOPE DETECTOR - TL071, +/-12 V - STANDARD PART VALUES
* Key nodes: 3=MESSAGE  9=TRIANGLE  12=SQUARE  16=FM OUT (sine)  19=DIFFERENTIATOR
*            24=FULL-WAVE RECTIFIED  33=LOW-PASS  29=AUDIO OUT
*
* ---------------- Supplies ----------------
VCC 1 0 DC 12
VEE 2 0 DC -12
*
* ---------------- Message (function generator) ----------------
VM  3 0 SIN(0 2.5 2K)          ; message 2 kHz (use 1K for 1 kHz)
*
* ================= TRANSMITTER =================
* A1: inverting summer -> node 5 = -(5 V + message)
R1  1 4 22K
R2  3 4 10K
R3  4 5 10K
X1  0 4 1 2 5 TL071
* A2: inverter -> node 7 = +(5 V + message)  (control voltage)
R4  5 6 10K
R5  6 7 10K
X2  0 6 1 2 7 TL071
* A3: integrator with diode-steered input current (triangle at node 9)
C1  8 9 470P
C1B 8 9 100P                   ; 470p + 100p in parallel = 570 pF
X3  0 8 1 2 9 TL071
D1  8 10 D1N4148
R6  10 35 10K
R6B 35 5 10K                   ; 10k + 10k in series = 20k
R7  7 11 10K
D2  11 8 D1N4148
D3  11 12 D1N4148
* A4: Schmitt trigger (square at node 12)
R8  9 13 10K
R9  12 13 47K
X4  13 0 1 2 12 TL071
* Triangle-to-sine shaper
R10 9 14 4.7K
R11 14 0 2.2K
D4  14 0 D1N4148
D5  0 14 D1N4148
* A5: non-inverting amplifier -> FM OUT (node 16)
X5  14 15 1 2 16 TL071
R12 15 0 10K
R13 16 15 82K
C6  16 15 10P                  ; keeps the FM amplitude flat across the frequency swing
*
* ================= RECEIVER =================
* A6: differentiator = slope detector (output amplitude proportional to frequency)
R14 16 17 1K
C2  17 18 220P
R15 18 19 12K
C3  18 19 22P
X6  0 18 1 2 19 TL071
* A7 + A8: precision full-wave rectifier (node 24 = -|v|)
R16 19 20 10K
X7  0 20 1 2 21 TL071
D6  20 21 D1N4148
D7  21 22 D1N4148
R17 22 20 10K
R18 19 23 10K
R19 22 23 10K
R19B 22 23 10K                 ; two 10k in parallel = 5k
R20 23 24 10K
X8  0 23 1 2 24 TL071
* A9 + A11: 4-pole Butterworth low-pass (about 8 kHz) - removes carrier ripple
R21 24 25 10K
R22 25 26 10K
C4  25 27 2.2N
C5  26 0 1.5N
X9  26 27 1 2 27 TL071
R27 27 31 15K
R28 31 32 15K
C7  31 33 3.3N
C8  32 0 470P
X11 32 33 1 2 33 TL071
* A10: phase-lead network (R29, C9) cancels the filter delay; R24+R25 remove the DC level
R23 33 28 12K
R29 33 34 1.8K
C9  34 28 4.7N
R24 1 28 82K                   ; sets the output DC level (use a 100k trimmer in hardware)
R26 28 29 33K
X10 0 28 1 2 29 TL071
*
* ================= MODELS =================
.MODEL D1N4148 D(IS=2.52N RS=0.568 N=1.752 CJO=4P M=0.4 TT=20N
+ BV=100 IBV=100U)
*
* TL071 macromodel  (pins: non-inv input, inv input, V+, V-, output)
.SUBCKT TL071 1 2 3 4 5
C1   11 12 3.498E-12
C2    6  7 15.00E-12
DC    5 53 DX
DE   54  5 DX
DLP  90 91 DX
DLN  92 90 DX
DP    4  3 DX
EGND 99  0 POLY(2) (3,0) (4,0) 0 .5 .5
FB    7 99 POLY(5) VB VC VE VLP VLN 0 4.715E6 -5E6 5E6 5E6 -5E6
GA    6  0 11 12 282.8E-6
GCM   0  6 10 99 8.942E-9
ISS   3 10 DC 195.0E-6
HLIM 90  0 VLIM 1K
J1   11  2 10 JX
J2   12  1 10 JX
R2    6  9 100.0E3
RD1   4 11 3.536E3
RD2   4 12 3.536E3
RO1   8  5 150
RO2   7 99 150
RP    3  4 2.143E3
RSS  10 99 1.026E6
VB    9  0 DC 0
VC    3 53 DC 2.200
VE   54  4 DC 2.200
VLIM  7  8 DC 0
VLP  91  0 DC 25
VLN   0 92 DC 25
.MODEL DX D(IS=800.0E-18)
.MODEL JX PJF(IS=15.00E-12 BETA=270.1E-6 VTO=-1)
.ENDS
*
.OPTIONS ITL5=0
.TRAN 20N 2.5M 0 20N
.PROBE
.END
