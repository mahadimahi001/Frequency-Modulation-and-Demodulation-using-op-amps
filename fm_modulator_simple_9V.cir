SIMPLE VARACTOR FM MODULATOR - 9V BATTERY
* Nodes: 1=+9V 2=base 3,9=tank ends 5=collector 7=bias 8=varactors 21=FM OUT
* Supply
V2 1 0 DC 9
* Message = function generator (50 ohm output), 5 V peak, 15 kHz
VG 12 0 SIN(0 5 15K)
RG 12 6 50
C6 6 7 1U
* Varactor bias divider: 9 V x 20k/30k = 6 V
R8 1 7 10K
R9 7 0 20K
R5 7 8 1K
* Oscillator
Q1 5 2 4 Q2N3904
R1 1 2 27K
R2 2 0 10K
R3 1 5 2.2K
R4 4 10 100
R7 10 0 2.2K
C1 10 0 10U
C2 5 3 100N
C3 2 9 2.2N
L1 3 9 2.2M
C4 3 0 100P
C5 9 0 100P
R6 3 0 1MEG
D1 3 8 DBB112
D2 9 8 DBB112
* Output: coupling cap + diode limiter
C7 3 11 1N
R10 11 21 47K
D3 21 0 D1N4148
D4 0 21 D1N4148
* Models
.MODEL Q2N3904 NPN(IS=6.734F XTI=3 EG=1.11 VAF=74.03 BF=416.4 NE=1.259
+ ISE=6.734F IKF=66.78M XTB=1.5 BR=.7371 NC=2 ISC=0 IKR=0 RC=1
+ CJC=3.638P MJC=.3085 VJC=.75 FC=.5 CJE=4.493P MJE=.2593 VJE=.75
+ TR=239.5N TF=301.2P ITF=.4 VTF=4 XTF=2 RB=10)
.MODEL DBB112 D(IS=1E-14 RS=0.0011 CJO=2.324E-9 VJ=0.75 TT=5E-9 M=0.9
+ BV=100 N=1 EG=1.11 XTI=3 FC=0.5 IBV=0.0001)
.MODEL D1N4148 D(IS=2.52N RS=0.568 N=1.752 CJO=4P M=0.4 TT=20N
+ BV=100 IBV=100U)
.TRAN 10N 1M 0 10N
.PROBE
.END
