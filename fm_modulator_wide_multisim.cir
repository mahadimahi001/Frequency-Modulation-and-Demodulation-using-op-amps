FM MODULATOR WIDE DEVIATION - MULTISIM VERSION
* Supplies and message
V2 1 0 DC 12
V3 6 0 SIN(0 11 15K)
V1 7 6 DC 12
I1 3 9 PULSE(0 1M 0 10N 10N 1U 1)
* Oscillator transistor
Q1 5 2 4 Q2N3394
R1 1 2 28K
R2 2 0 10K
R3 1 5 2.2K
R4 4 10 100
R7 10 0 2.2K
C1 10 0 10U
* Tank
C2 5 3 100N
C3 2 9 2.2N
L1 3 9 2.2M
C4 3 0 100P
C5 9 0 100P
R6 3 0 1MEG
* Back-to-back varactors
D1 3 8 DBB112
D2 9 8 DBB112
R5 7 8 1K
* Output stage: node 20 = V(3)-V(9), node 21 = limited FM output
E1 20 0 3 9 1
RL1 20 0 10K
R8 20 21 10K
D3 21 0 D1N4148
D4 0 21 D1N4148
* Models
.MODEL Q2N3394 NPN(IS=61.01F XTI=3 EG=1.11 VAF=57.37 BF=121.3 NE=1.305
+ ISE=122.2F IKF=97.79M XTB=1.5 BR=.2359 NC=2 ISC=0 IKR=0 RC=2.14
+ CJC=6.072P MJC=.3333 VJC=.75 FC=.5 CJE=5.928P MJE=.3333 VJE=.75
+ TR=1.633U TF=316.3P ITF=.2 VTF=5 XTF=8 RB=10)
.MODEL DBB112 D(IS=1E-14 RS=0.0011 CJO=2.324E-9 VJ=0.75 TT=5E-9 M=0.9
+ BV=100 N=1 EG=1.11 XTI=3 FC=0.5 IBV=0.0001)
.MODEL D1N4148 D(IS=2.52N RS=0.568 N=1.752 CJO=4P M=0.4 TT=20N
+ BV=100 IBV=100U)
.TRAN 10N 1M 0 10N
.END
